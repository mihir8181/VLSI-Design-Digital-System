ADE simulation setup
Run mode: Single Run, Sweeps and Corners
Tests:
  EEE_234_Project1:D_FlipFlop_TB_2:1: EEE_234_Project1/D_FlipFlop_TB_2/schematic, simulator spectre
